ADE simulation setup
Run mode: Single Run, Sweeps and Corners
Tests:
  COUNTER_counter_tb_1: COUNTER/counter_tb/config, simulator ams
