ADE simulation setup
Test COUNTER_counter_tb_1: COUNTER/counter_tb/config, simulator ams
  Models: $AMS_MODELPATH/processOption.scs, $AMS_MODELPATH/cmos53.scs[cmostm], $AMS_MODELPATH/res.scs[restm], $AMS_MODELPATH/cap.scs[captm], $AMS_MODELPATH/bip.scs[biptm], $AMS_MODELPATH/esddiode.scs[esddiodetm], $AMS_MODELPATH/soac.scs
  Temperature: 27
  Simulator options: reltol=100e-6 homotopy=all
  Analysis tran: stop=1u errpreset=conservative
  Signals: /clk, /enable, /reset, /out<7:0>
Run mode: Single Run, Sweeps and Corners
