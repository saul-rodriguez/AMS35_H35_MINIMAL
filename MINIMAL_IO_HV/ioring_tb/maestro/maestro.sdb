ADE simulation setup
Run mode: Single Run, Sweeps and Corners
Tests:
  MINIMAL_IO_HV_ioring_tb_1 (off): MINIMAL_IO_HV/ioring_tb/config, simulator spectre
    Variables: AIN = 1.5; AOUT = 0.7; CLK = 1; ENABLE = 1; RESET = 1; VDDA = 3.1; VDDD = 3.3
  MINIMAL_IO_HV_ioring_tb_1_1: MINIMAL_IO_HV/ioring_tb/config_behav, simulator ams
    Variables: AIN = 1.5; AOUT = 0.7; CLK = 1; ENABLE = 0; RESET = 1; VDDA = 3.1; VDDD = 3.3
