ADE simulation setup
Test MINIMAL_IO_HV_ioring_tb_1: MINIMAL_IO_HV/ioring_tb/config, simulator spectre
  Models: $AMS_MODELPATH/processOption.scs, $AMS_MODELPATH/cmos53.scs[cmostm], $AMS_MODELPATH/res.scs[restm], $AMS_MODELPATH/cap.scs[captm], $AMS_MODELPATH/bip.scs[biptm], $AMS_MODELPATH/esddiode.scs[esddiodetm], $AMS_MODELPATH/soac.scs
  Variables: VDDA = 3.1; VDDD = 3.3; AIN = 1.5; AOUT = 0.7; CLK = 1; ENABLE = 1; RESET = 1
  Temperature: 27
  Simulator options: reltol=100e-6 homotopy=all
  Analysis dc: (saves the operating point)
Test MINIMAL_IO_HV_ioring_tb_1_1: MINIMAL_IO_HV/ioring_tb/config_behav, simulator ams
  Models: $AMS_MODELPATH/processOption.scs, $AMS_MODELPATH/cmos53.scs[cmostm], $AMS_MODELPATH/res.scs[restm], $AMS_MODELPATH/cap.scs[captm], $AMS_MODELPATH/bip.scs[biptm], $AMS_MODELPATH/esddiode.scs[esddiodetm], $AMS_MODELPATH/soac.scs
  Variables: VDDA = 3.1; VDDD = 3.3; AIN = 1.5; AOUT = 0.7; CLK = 1; ENABLE = 0; RESET = 1
  Temperature: 27
  Analysis dc: (saves the operating point)
  Analysis tran: stop=10u errpreset=conservative
  Signals: /e, /r, /c, /ENABLE, /RESET, /CLK
Run mode: Single Run, Sweeps and Corners
Disabled tests: MINIMAL_IO_HV_ioring_tb_1
