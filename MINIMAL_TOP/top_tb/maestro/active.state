ADE simulation setup
Test MINIMAL_TOP_top_tb_1: MINIMAL_TOP/top_tb/config_functional, simulator ams
  Models: $AMS_MODELPATH/processOption.scs, $AMS_MODELPATH/cmos53.scs[cmostm], $AMS_MODELPATH/res.scs[restm], $AMS_MODELPATH/cap.scs[captm], $AMS_MODELPATH/bip.scs[biptm], $AMS_MODELPATH/esddiode.scs[esddiodetm], $AMS_MODELPATH/soac.scs
  Variables: VDDA = 3.3; VDDD = 3.3
  Temperature: 27
  Analysis tran: stop=2u errpreset=conservative
  Signals: /clk, /enable, /reset, /ain2, /aout2, /aout1, /c0, /c1, /c2
Run mode: Single Run, Sweeps and Corners
