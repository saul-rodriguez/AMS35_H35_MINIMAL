ADE simulation setup
Run mode: Single Run, Sweeps and Corners
Tests:
  MINIMAL_TOP_top_tb_1: MINIMAL_TOP/top_tb/config_dig_schem_analog_schem, simulator ams
    Variables: VDDA = 3.3; VDDD = 3.3
